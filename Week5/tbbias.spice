.option ngbehavior=hsa
.lib /opt/pdk/sky130A/libs.tech/ngspice/sky130.lib.spice tt
.include bias.spice

V_VDD VDD GND 1.8
V_vctrl vctrl GND 0.6

X1 vctrl Vp Vn VDD GND vco_bias

.control
  alter V_vctrl 0.4
  op
  print v(Vp) v(Vn)

  alter V_vctrl 0.7
  op
  print v(Vp) v(Vn)

  alter V_vctrl 1.0
  op
  print v(Vp) v(Vn)

  alter V_vctrl 1.3
  op
  print v(Vp) v(Vn)

  alter V_vctrl 1.6
  op
  print v(Vp) v(Vn)
.endc
.end
