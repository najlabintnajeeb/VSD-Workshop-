* Testbench for cs_inv Logic & Propagation Delay
.option ngbehavior=hsa
.lib /opt/pdk/sky130A/libs.tech/ngspice/sky130.lib.spice tt
.include /opt/pdk/sky130B/libs.ref/sky130_fd_sc_hd/spice/sky130_fd_sc_hd.spice
.include cs.spice

V_VDD VDD GND 1.8
V_Vn Vn GND 1.8
V_Vp Vp GND 0.0
V_IN in GND PULSE(0 1.8 1n 10p 10p 100n 220n)
X1 Vp in out Vn VDD GND cs_inv

.options reltol=1e-6 vntol=1e-9 abstol=1e-12
.tran 0.5p 50n

.control
  * --- Point 1: Vp=0.0, Vn=1.8 ---
  alter V_Vp 0.0
  alter V_Vn 1.8
  tran 0.5p 210n
plot v(in) v(out)
  meas tran t_pd_fall1 TRIG in VAL=0.9 RISE=1 TARG out VAL=0.9 FALL=1
  meas tran t_pd_rise1 TRIG in VAL=0.9 FALL=1 TARG out VAL=0.9 RISE=1
  print t_pd_fall1 t_pd_rise1

  * --- Point 2: Vp=0.3, Vn=1.5 ---
  alter V_Vp 0.3
  alter V_Vn 1.5
  tran 0.5p 210n
plot v(in) v(out)
  meas tran t_pd_fall2 TRIG in VAL=0.9 RISE=1 TARG out VAL=0.9 FALL=1
  meas tran t_pd_rise2 TRIG in VAL=0.9 FALL=1 TARG out VAL=0.9 RISE=1
  print t_pd_fall2 t_pd_rise2

  * --- Point 3: Vp=0.6, Vn=1.2 ---
  alter V_Vp 0.6
  alter V_Vn 1.2
  tran 0.5p 210n
plot v(in) v(out)
  meas tran t_pd_fall3 TRIG in VAL=0.9 RISE=1 TARG out VAL=0.9 FALL=1
  meas tran t_pd_rise3 TRIG in VAL=0.9 FALL=1 TARG out VAL=0.9 RISE=1
  print t_pd_fall3 t_pd_rise3

  * --- Point 4: Vp=0.9, Vn=0.9 ---
  alter V_Vp 0.9
  alter V_Vn 0.9
  tran 0.5p 210n
plot v(in) v(out)
  meas tran t_pd_fall4 TRIG in VAL=0.9 RISE=1 TARG out VAL=0.9 FALL=1
  meas tran t_pd_rise4 TRIG in VAL=0.9 FALL=1 TARG out VAL=0.9 RISE=1
  print t_pd_fall4 t_pd_rise4

  * --- Point 5: Vp=1.2, Vn=0.6 ---
  alter V_Vp 1.2
  alter V_Vn 0.6
tran 0.5p 210n
plot v(in) v(out)
  meas tran t_pd_fall5 TRIG in VAL=0.9 RISE=1 TARG out VAL=0.9 FALL=1
  meas tran t_pd_rise5 TRIG in VAL=0.9 FALL=1 TARG out VAL=0.9 RISE=1
  print t_pd_fall5 t_pd_rise5
.endc
.end
