* Testbench for 5-stage ring VCO - 5-point Vctrl sweep (same points as 3-stage for comparison)
.option ngbehavior=hsa
.lib /opt/pdk/sky130A/libs.tech/ngspice/sky130.lib.spice tt
.include vco5.spice

V_VDD VDD GND 1.8
V_vctrl vctrl GND 0.75

X1 vctrl osc VDD GND vco5

.control
  * --- Point 1: Vctrl = 0.75V (wider window - 5-stage has longer loop delay) ---
  alter V_vctrl 0.75
  tran 5p 150n
  meas tran startup1 WHEN v(osc)=0.9 RISE=1
  meas tran t_period1 TRIG v(osc) VAL=0.9 RISE=2 TARG v(osc) VAL=0.9 RISE=3
  meas tran t_high1 TRIG v(osc) VAL=0.9 RISE=2 TARG v(osc) VAL=0.9 FALL=3
  meas tran i_avg1 AVG i(V_VDD) FROM=100n TO=150n
  let freq1 = 1/t_period1
  let duty1 = 100*t_high1/t_period1
  let power1 = abs(i_avg1)*1.8
  print startup1 t_period1 freq1 duty1 power1

  * --- Point 2: Vctrl = 0.9V ---
  alter V_vctrl 0.9
  tran 5p 100n
  meas tran startup2 WHEN v(osc)=0.9 RISE=1
  meas tran t_period2 TRIG v(osc) VAL=0.9 RISE=2 TARG v(osc) VAL=0.9 RISE=3
  meas tran t_high2 TRIG v(osc) VAL=0.9 RISE=2 TARG v(osc) VAL=0.9 FALL=3
  meas tran i_avg2 AVG i(V_VDD) FROM=20n TO=100n
  let freq2 = 1/t_period2
  let duty2 = 100*t_high2/t_period2
  let power2 = abs(i_avg2)*1.8
  print startup2 t_period2 freq2 duty2 power2

  * --- Point 3: Vctrl = 1.2V ---
  alter V_vctrl 1.2
  tran 5p 100n
  meas tran startup3 WHEN v(osc)=0.9 RISE=1
  meas tran t_period3 TRIG v(osc) VAL=0.9 RISE=2 TARG v(osc) VAL=0.9 RISE=3
  meas tran t_high3 TRIG v(osc) VAL=0.9 RISE=2 TARG v(osc) VAL=0.9 FALL=3
  meas tran i_avg3 AVG i(V_VDD) FROM=20n TO=100n
  let freq3 = 1/t_period3
  let duty3 = 100*t_high3/t_period3
  let power3 = abs(i_avg3)*1.8
  print startup3 t_period3 freq3 duty3 power3

  * --- Point 4: Vctrl = 1.5V ---
  alter V_vctrl 1.5
  tran 5p 100n
  meas tran startup4 WHEN v(osc)=0.9 RISE=1
  meas tran t_period4 TRIG v(osc) VAL=0.9 RISE=2 TARG v(osc) VAL=0.9 RISE=3
  meas tran t_high4 TRIG v(osc) VAL=0.9 RISE=2 TARG v(osc) VAL=0.9 FALL=3
  meas tran i_avg4 AVG i(V_VDD) FROM=20n TO=100n
  let freq4 = 1/t_period4
  let duty4 = 100*t_high4/t_period4
  let power4 = abs(i_avg4)*1.8
  print startup4 t_period4 freq4 duty4 power4

  * --- Point 5: Vctrl = 1.7V ---
  alter V_vctrl 1.7
  tran 5p 100n
  meas tran startup5 WHEN v(osc)=0.9 RISE=1
  meas tran t_period5 TRIG v(osc) VAL=0.9 RISE=2 TARG v(osc) VAL=0.9 RISE=3
  meas tran t_high5 TRIG v(osc) VAL=0.9 RISE=2 TARG v(osc) VAL=0.9 FALL=3
  meas tran i_avg5 AVG i(V_VDD) FROM=20n TO=100n
  let freq5 = 1/t_period5
  let duty5 = 100*t_high5/t_period5
  let power5 = abs(i_avg5)*1.8
  print startup5 t_period5 freq5 duty5 power5
.endc
.end
