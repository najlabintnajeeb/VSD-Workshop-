* NGSPICE file created from cs_inv_layout.ext - technology: sky130A

.subckt sky130_fd_pr__nfet_01v8_4BNSKG a_18_n42# a_n33_n130# a_n76_n42# a_n178_n216#
X0 a_18_n42# a_n33_n130# a_n76_n42# a_n178_n216# sky130_fd_pr__nfet_01v8 ad=0.1218 pd=1.42 as=0.1218 ps=1.42 w=0.42 l=0.18
.ends

.subckt sky130_fd_pr__pfet_01v8_X4438S a_18_n72# w_n214_n291# a_n33_n169# a_n76_n72#
X0 a_18_n72# a_n33_n169# a_n76_n72# w_n214_n291# sky130_fd_pr__pfet_01v8 ad=0.2088 pd=2.02 as=0.2088 ps=2.02 w=0.72 l=0.18
.ends

.subckt cs_inv_layout Vp in out Vn VDD GND
XXM1 m1_879_n1632# in out GND sky130_fd_pr__nfet_01v8_4BNSKG
XXM2 m1_917_n552# VDD Vp VDD sky130_fd_pr__pfet_01v8_X4438S
XXM3 out VDD in m1_917_n552# sky130_fd_pr__pfet_01v8_X4438S
XXM4 GND Vn m1_879_n1632# GND sky130_fd_pr__nfet_01v8_4BNSKG
.ends
