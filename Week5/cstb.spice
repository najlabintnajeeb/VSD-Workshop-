* Testbench for cs_inv Logic & Propagation Delay
.option ngbehavior=hsa
.lib /opt/pdk/sky130A/libs.tech/ngspice/sky130.lib.spice tt
.include /opt/pdk/sky130B/libs.ref/sky130_fd_sc_hd/spice/sky130_fd_sc_hd.spice
.include cs.spice

V_VDD VDD GND 1.8
V_Vn Vn GND 1.8
V_Vp Vp GND 0.0
V_IN in GND PULSE(0 1.8 1ns 10ps 10ps 5ns 10ns)

X1 Vp in out Vn VDD GND cs_inv

.options reltol=1e-6 vntol=1e-9 abstol=1e-12
.tran 0.5p 15n
.control
  run
  meas tran t_pd_fall TRIG in VAL=0.9 RISE=1 TARG out VAL=0.9 FALL=1
  meas tran t_pd_rise TRIG in VAL=0.9 FALL=1 TARG out VAL=0.9 RISE=1
  let t_pd = (t_pd_fall + t_pd_rise)/2
  print t_pd_fall t_pd_rise t_pd
  plot v(in) v(out)
.endc
.end
