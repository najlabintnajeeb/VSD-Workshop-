* Testbench for vco_bias - DC sweep of Vctrl, plots Vp and Vn
.option ngbehavior=hsa
.lib /opt/pdk/sky130A/libs.tech/ngspice/sky130.lib.spice tt
.include bias.spice

V_VDD VDD GND 1.8
V_vctrl vctrl GND 0.6

X1 vctrl Vp Vn VDD GND vco_bias

.control
  dc V_vctrl 0.4 1.6 0.05
  plot v(Vp) v(Vn) xlabel "Vctrl (V)" ylabel "Voltage (V)"
  hardcopy vco_bias_sweep.ps v(Vp) v(Vn)
.endc
.end
